** sch_path: /home/madvlsi/Desktop/Mixed-Signal TRNG/xschem/ro.sch
**.subckt ro RO_TAP_1 RO_TAP_2 RO_TAP_3 RO_TAP_4 RO_OUT VN VP
*.opin RO_OUT
*.ipin VP
*.ipin VN
*.opin RO_TAP_1
*.opin RO_TAP_2
*.opin RO_TAP_3
*.opin RO_TAP_4
x1 VP RO_OUT net1 VN inv
x2 VP net1 net2 VN inv
x3 VP net2 net3 VN inv
x4 VP net3 net4 VN inv
x5 VP net4 RO_OUT VN inv
VDD VP GND 1.8
VGND VN GND 0
x6 VP net1 RO_TAP_1 VN inv_tap
x7 VP net2 RO_TAP_2 VN inv_tap
x8 VP net3 RO_TAP_3 VN inv_tap
x9 VP net4 RO_TAP_4 VN inv_tap
**** begin user architecture code

.tran 0.01n 10n
.save all

.lib /usr/local/share/pdk/sky130A/libs.tech/combined/sky130.lib.spice tt
**** end user architecture code
**.ends

* expanding   symbol:  /home/madvlsi/Desktop/Mixed-Signal TRNG/xschem/inv.sym # of pins=4
** sym_path: /home/madvlsi/Desktop/Mixed-Signal TRNG/xschem/inv.sym
** sch_path: /home/madvlsi/Desktop/Mixed-Signal TRNG/xschem/inv.sch
.subckt inv VP IN OUT VN
*.ipin IN
*.opin OUT
*.ipin VP
*.ipin VN
XM1 OUT IN VN VN sky130_fd_pr__nfet_01v8 L=0.15 W=2 nf=1 ad='int((nf+1)/2) * W/nf * 0.29' as='int((nf+2)/2) * W/nf * 0.29' pd='2*int((nf+1)/2) * (W/nf + 0.29)'
+ ps='2*int((nf+2)/2) * (W/nf + 0.29)' nrd='0.29 / W' nrs='0.29 / W' sa=0 sb=0 sd=0 mult=1 m=1
XM2 OUT IN VP VP sky130_fd_pr__pfet_01v8 L=0.15 W=4 nf=1 ad='int((nf+1)/2) * W/nf * 0.29' as='int((nf+2)/2) * W/nf * 0.29' pd='2*int((nf+1)/2) * (W/nf + 0.29)'
+ ps='2*int((nf+2)/2) * (W/nf + 0.29)' nrd='0.29 / W' nrs='0.29 / W' sa=0 sb=0 sd=0 mult=1 m=1
.ends

* expanding   symbol:  /home/madvlsi/Desktop/Mixed-Signal TRNG/xschem/inv_tap.sym # of pins=4
** sym_path: /home/madvlsi/Desktop/Mixed-Signal TRNG/xschem/inv_tap.sym
** sch_path: /home/madvlsi/Desktop/Mixed-Signal TRNG/xschem/inv_tap.sch
.subckt inv_tap VP IN OUT VN
*.ipin IN
*.opin OUT
*.ipin VP
*.ipin VN
XM1 OUT IN VN VN sky130_fd_pr__nfet_01v8 L=0.15 W=0.6 nf=1 ad='int((nf+1)/2) * W/nf * 0.29' as='int((nf+2)/2) * W/nf * 0.29' pd='2*int((nf+1)/2) * (W/nf + 0.29)'
+ ps='2*int((nf+2)/2) * (W/nf + 0.29)' nrd='0.29 / W' nrs='0.29 / W' sa=0 sb=0 sd=0 mult=1 m=1
XM2 OUT IN VP VP sky130_fd_pr__pfet_01v8 L=0.15 W=1.2 nf=1 ad='int((nf+1)/2) * W/nf * 0.29' as='int((nf+2)/2) * W/nf * 0.29' pd='2*int((nf+1)/2) * (W/nf + 0.29)'
+ ps='2*int((nf+2)/2) * (W/nf + 0.29)' nrd='0.29 / W' nrs='0.29 / W' sa=0 sb=0 sd=0 mult=1 m=1
.ends

.GLOBAL GND
.end
