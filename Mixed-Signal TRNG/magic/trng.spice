* NGSPICE file created from trng.ext - technology: sky130A

.subckt inv_tap VP VN IN OUT
X0 OUT IN VP VP sky130_fd_pr__pfet_01v8 ad=0.6 pd=3.4 as=0.6 ps=3.4 w=1.2 l=0.15
X1 OUT IN VN VN sky130_fd_pr__nfet_01v8 ad=0.3 pd=2.2 as=0.3 ps=2.2 w=0.6 l=0.15
.ends

.subckt inv VP VN IN OUT
X0 OUT IN VN VN sky130_fd_pr__nfet_01v8 ad=1 pd=5 as=1 ps=5 w=2 l=0.15
X1 OUT IN VP VP sky130_fd_pr__pfet_01v8 ad=2 pd=9 as=2 ps=9 w=4 l=0.15
.ends

.subckt ro RO_OUT RO_TAP_1 RO_TAP_2 RO_TAP_3 RO_TAP_4 VP VN
Xinv_tap_0 VP VN inv_1/IN RO_TAP_1 inv_tap
Xinv_tap_1 VP VN inv_2/IN RO_TAP_2 inv_tap
Xinv_tap_2 VP VN inv_3/IN RO_TAP_3 inv_tap
Xinv_tap_3 VP VN inv_4/IN RO_TAP_4 inv_tap
Xinv_0 VP VN RO_OUT inv_1/IN inv
Xinv_1 VP VN inv_1/IN inv_2/IN inv
Xinv_2 VP VN inv_2/IN inv_3/IN inv
Xinv_3 VP VN inv_3/IN inv_4/IN inv
Xinv_4 VP VN inv_4/IN RO_OUT inv
.ends

.subckt dff Dn1 Qn Q D Dn2 VP VN CLK a_n100_1320#
X0 Q CLK a_910_0# VP sky130_fd_pr__pfet_01v8 ad=2 pd=9 as=2 ps=9 w=4 l=0.15
X1 a_320_n1230# a_320_n620# a_n100_1320# VP sky130_fd_pr__pfet_01v8 ad=1 pd=5 as=1 ps=5 w=2 l=0.15
X2 a_30_n420# D VN VN sky130_fd_pr__nfet_01v8 ad=0.5 pd=3 as=0.5 ps=3 w=1 l=0.15
X3 a_30_n1230# Dn2 VN VN sky130_fd_pr__nfet_01v8 ad=0.5 pd=3 as=0.5 ps=3 w=1 l=0.15
X4 Qn CLK a_910_1320# VP sky130_fd_pr__pfet_01v8 ad=2 pd=9 as=2 ps=9 w=4 l=0.15
X5 Qn Q a_780_n1230# VN sky130_fd_pr__nfet_01v8 ad=1 pd=5 as=1 ps=5 w=2 l=0.15
X6 a_780_n1230# CLK VN VN sky130_fd_pr__nfet_01v8 ad=1 pd=5 as=1 ps=5 w=2 l=0.15
X7 a_n100_1320# CLK VP VP sky130_fd_pr__pfet_01v8 ad=2 pd=9 as=2 ps=9 w=4 l=0.15
X8 a_320_n620# a_320_n1230# a_n100_0# VP sky130_fd_pr__pfet_01v8 ad=1 pd=5 as=1 ps=5 w=2 l=0.15
X9 Q Qn a_780_n420# VN sky130_fd_pr__nfet_01v8 ad=1 pd=5 as=1 ps=5 w=2 l=0.15
X10 a_320_n620# CLK a_30_n420# VN sky130_fd_pr__nfet_01v8 ad=1 pd=5 as=1 ps=5 w=2 l=0.15
X11 a_910_1320# a_320_n1230# VP VP sky130_fd_pr__pfet_01v8 ad=1 pd=5 as=1 ps=5 w=2 l=0.15
X12 VN a_320_n1230# a_780_n1230# VN sky130_fd_pr__nfet_01v8 ad=0.5 pd=3 as=0.5 ps=3 w=1 l=0.15
X13 VP Q Qn VP sky130_fd_pr__pfet_01v8 ad=2 pd=9 as=2 ps=9 w=4 l=0.15
X14 VN a_320_n1230# a_320_n620# VN sky130_fd_pr__nfet_01v8 ad=0.5 pd=3 as=0.5 ps=3 w=1 l=0.15
X15 VP Qn Q VP sky130_fd_pr__pfet_01v8 ad=2 pd=9 as=2 ps=9 w=4 l=0.15
X16 a_n100_0# CLK VP VP sky130_fd_pr__pfet_01v8 ad=2 pd=9 as=2 ps=9 w=4 l=0.15
X17 a_780_n420# CLK VN VN sky130_fd_pr__nfet_01v8 ad=1 pd=5 as=1 ps=5 w=2 l=0.15
X18 VN a_320_n620# a_320_n1230# VN sky130_fd_pr__nfet_01v8 ad=0.5 pd=3 as=0.5 ps=3 w=1 l=0.15
X19 VP Dn1 a_n100_1320# VP sky130_fd_pr__pfet_01v8 ad=1 pd=5 as=1 ps=5 w=2 l=0.15
X20 a_320_n1230# CLK a_30_n1230# VN sky130_fd_pr__nfet_01v8 ad=1 pd=5 as=1 ps=5 w=2 l=0.15
X21 VN a_320_n620# a_780_n420# VN sky130_fd_pr__nfet_01v8 ad=0.5 pd=3 as=0.5 ps=3 w=1 l=0.15
X22 a_910_0# a_320_n620# VP VP sky130_fd_pr__pfet_01v8 ad=1 pd=5 as=1 ps=5 w=2 l=0.15
X23 VP D a_n100_0# VP sky130_fd_pr__pfet_01v8 ad=1 pd=5 as=1 ps=5 w=2 l=0.15
.ends

.subckt xor B Bn Y VP A VN An
X0 a_130_n670# B A VP sky130_fd_pr__pfet_01v8 ad=2 pd=9 as=2 ps=9 w=4 l=0.15
X1 Y a_910_n670# VN VN sky130_fd_pr__nfet_01v8 ad=1 pd=5 as=1 ps=5 w=2 l=0.15
X2 a_130_n670# Bn An VP sky130_fd_pr__pfet_01v8 ad=2 pd=9 as=2 ps=9 w=4 l=0.15
X3 Y a_910_n670# VP VP sky130_fd_pr__pfet_01v8 ad=2 pd=9 as=2 ps=9 w=4 l=0.15
X4 a_130_n670# B An VN sky130_fd_pr__nfet_01v8 ad=1 pd=5 as=1 ps=5 w=2 l=0.15
X5 a_910_n670# a_130_n670# VN VN sky130_fd_pr__nfet_01v8 ad=1 pd=5 as=1 ps=5 w=2 l=0.15
X6 a_130_n670# Bn A VN sky130_fd_pr__nfet_01v8 ad=1 pd=5 as=1 ps=5 w=2 l=0.15
X7 a_910_n670# a_130_n670# VP VP sky130_fd_pr__pfet_01v8 ad=2 pd=9 as=2 ps=9 w=4 l=0.15
.ends

.subckt trng CLK VP VN TRNG_OUT RO_OUT CLKn
Xro_0 RO_OUT dff_2/D dff_0/D dff_3/D dff_1/D VP VN ro
Xdff_0 CLKn xor_1/An xor_1/A dff_0/D CLK VP VN CLK dff_0/a_n100_1320# dff
Xdff_1 CLKn xor_1/Bn xor_1/B dff_1/D CLK VP VN CLK li_2340_4870# dff
Xdff_2 CLKn xor_2/An xor_2/A dff_2/D CLK VP VN CLK dff_2/a_n100_1320# dff
Xdff_3 CLKn xor_2/Bn xor_2/B dff_3/D CLK VP VN CLK dff_3/a_n100_1320# dff
Xinv_tap_0 VP VN xor_2/Y xor_0/Bn inv_tap
Xinv_tap_1 VP VN xor_1/Y xor_0/An inv_tap
Xinv_tap_2 VP VN CLK CLKn inv_tap
Xxor_0 xor_2/Y xor_0/Bn TRNG_OUT VP xor_1/Y VN xor_0/An xor
Xxor_1 xor_1/B xor_1/Bn xor_1/Y VP xor_1/A VN xor_1/An xor
Xxor_2 xor_2/B xor_2/Bn xor_2/Y VP xor_2/A VN xor_2/An xor
.ends
